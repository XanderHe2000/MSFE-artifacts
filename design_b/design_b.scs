// SPDX-License-Identifier: CERN-OHL-P-2.0
// Licensed under CERN Open Hardware Licence Version 2 - Permissive.
// See ../LICENSE.
// Sanitized release: hierarchy and transistor W/L retained.
// Generic models are placeholders and are not performance-equivalent.
simulator lang=spectre
global 0
include "generic_models.scs"

// Cell: block_b1
subckt block_b1 BOT TOP VSS
    C1 (TOP BOT) MOMCAP_GENERIC c_nom=87.5785f
    C3 (BOT TOP) MOMCAP_GENERIC c_nom=87.5785f
    C2 (BOT VSS) capacitor c=10f
ends block_b1
// End of subcircuit definition.

// Cell: block_b2
subckt block_b2 CLK CLKBS VDD VIN VSS
    M0 (CLKBS net1 TOP TOP) PMOS_GENERIC l=30n w=4u m=1
    M1 (TOP CLKBS VDD TOP) PMOS_GENERIC l=30n w=2u m=1
    C0 (TOP BOT) MOMCAP_GENERIC c_nom=134.807f
    M14 (net1 CLKBS BOT VSS) NMOS_GENERIC l=30n w=2u m=1
    M7 (net2 PHIE VSS VSS) NMOS_GENERIC l=30n w=4u m=1
    M3 (CLKBS VDD net2 VSS) NMOS_GENERIC l=30n w=4u m=1
    M15 (BOT PHIE VSS VSS) NMOS_GENERIC l=30n w=2u m=1
    M13 (VIN CLKBS BOT VSS) NMOS_GENERIC l=30n w=4u m=1
    M12 (CLKBUF PHIE VDD VDD) PMOS_LVT_GENERIC l=30n w=1.04u m=1
    M6 (PHIE CLK VDD VDD) PMOS_LVT_GENERIC l=30n w=1.04u m=1
    M8 (net1 CLKBUF VDD VDD) PMOS_LVT_GENERIC l=30n w=2.08u m=1
    M11 (CLKBUF PHIE VSS VSS) NMOS_LVT_GENERIC l=30n w=800n m=1
    M4 (net1 CLKBUF BOT VSS) NMOS_LVT_GENERIC l=30n w=1.6u m=1
    M5 (PHIE CLK VSS VSS) NMOS_LVT_GENERIC l=30n w=800n m=1
ends block_b2
// End of subcircuit definition.

// Cell: block_b3
subckt block_b3 BOT TOP VSS
    C2 (BOT TOP) MOMCAP_GENERIC c_nom=270.243f
    C0 (TOP BOT) MOMCAP_GENERIC c_nom=270.243f
    C3 (BOT VSS) capacitor c=5f
    C1 (TOP VSS) capacitor c=5f
ends block_b3
// End of subcircuit definition.

// Cell: block_b4
subckt block_b4 EN EN0 ENP IBIAS1 IBIAS2 RST RST2 RSTP RSTP2 VBNN VBNP VBPN VBPP VCM2 VCMD VDD VDDC VDDN VDDP VIN VINC VIP VIPC VOUTN VOUTP VSS VSSC VSSN VSSP
    M8 (VSSC RST2 VSSP VSS) NMOS_GENERIC l=30n w=10u m=1
    M12 (VSSC RST2 VSSN VSS) NMOS_GENERIC l=30n w=10u m=1
    M46 (VSSC RST VSSR VSS) NMOS_GENERIC l=30n w=5u m=1
    M40 (VIPC VBSP VIP VSS) NMOS_GENERIC l=30n w=10u m=3
    M41 (VINC VBSN VIN VSS) NMOS_GENERIC l=30n w=10u m=3
    M6 (net4 EN VBPR VSS) NMOS_LVT_GENERIC l=30n w=5u m=1
    M185 (net3 net1 VSS VSS) NMOS_LVT_GENERIC l=60n w=16.0u m=1
    M182 (net1 net1 VSS VSS) NMOS_LVT_GENERIC l=60n w=16.0u m=1
    M222 (VCM2 RST2 VOUTP VSS) NMOS_LVT_GENERIC l=30n w=2u m=1
    M227 (VCM2 RST2 VOUTN VSS) NMOS_LVT_GENERIC l=30n w=2u m=1
    M200 (CMBP IBIAS2 VSS VSS) NMOS_LVT_GENERIC l=60n w=2u m=1
    M201 (IBIAS2 IBIAS2 VSS VSS) NMOS_LVT_GENERIC l=60n w=4u m=1
    M241 (VBN2 RST VBNR VSS) NMOS_LVT_GENERIC l=30n w=2u m=1
    M239 (VBP2 RST VBPR VSS) NMOS_LVT_GENERIC l=30n w=2u m=1
    M235 (net6 IBIAS1 VSS VSS) NMOS_LVT_GENERIC l=60n w=6u m=1
    M236 (net5 VCN net6 VSS) NMOS_LVT_GENERIC l=60n w=6u m=1
    M234 (net5 EN VDDR VSS) NMOS_LVT_GENERIC l=30n w=3u m=1
    M244\<5\> (VSS VSS VSS VSS) NMOS_LVT_GENERIC l=60n w=5u m=1
    M244\<4\> (VSS VSS VSS VSS) NMOS_LVT_GENERIC l=60n w=5u m=1
    M244\<3\> (VSS VSS VSS VSS) NMOS_LVT_GENERIC l=60n w=5u m=1
    M244\<2\> (VSS VSS VSS VSS) NMOS_LVT_GENERIC l=60n w=5u m=1
    M244\<1\> (VSS VSS VSS VSS) NMOS_LVT_GENERIC l=60n w=5u m=1
    M245\<7\> (VSS VSS VN0 VSS) NMOS_LVT_GENERIC l=60n w=1u m=1
    M245\<6\> (VN0 VSS VN1 VSS) NMOS_LVT_GENERIC l=60n w=1u m=1
    M245\<5\> (VN1 VSS VBP1 VSS) NMOS_LVT_GENERIC l=60n w=1u m=1
    M245\<4\> (VBP1 VSS VBN1 VSS) NMOS_LVT_GENERIC l=60n w=1u m=1
    M245\<3\> (VBN1 VSS VN2 VSS) NMOS_LVT_GENERIC l=60n w=1u m=1
    M245\<2\> (VN2 VSS VN3 VSS) NMOS_LVT_GENERIC l=60n w=1u m=1
    M245\<1\> (VN3 VSS VSS VSS) NMOS_LVT_GENERIC l=60n w=1u m=1
    M212 (VBP2 VCN VN3 VSS) NMOS_LVT_GENERIC l=60n w=4u m=1
    M95 (VN3 IBIAS1 VSS VSS) NMOS_LVT_GENERIC l=60n w=4u m=1
    M96 (VBN2 VBN2 VSS VSS) NMOS_LVT_GENERIC l=60n w=4u m=1
    M172 (VBN1 VBN1 VCMD VSS) NMOS_LVT_GENERIC l=60n w=8u m=1
    M170 (VCP VCN VN2 VSS) NMOS_LVT_GENERIC l=60n w=4u m=1
    M131 (IBIAS1 VCN VN0 VSS) NMOS_LVT_GENERIC l=60n w=4u m=1
    M137 (VCN VCN VBP1 VSS) NMOS_LVT_GENERIC l=60n w=4u m=1
    M169 (PBIAS VCN VN1 VSS) NMOS_LVT_GENERIC l=60n w=8u m=1
    M166 (VN2 IBIAS1 VSS VSS) NMOS_LVT_GENERIC l=60n w=4u m=1
    M136 (VBP1 IBIAS1 VSS VSS) NMOS_LVT_GENERIC l=60n w=4u m=1
    M165 (VN1 IBIAS1 VSS VSS) NMOS_LVT_GENERIC l=60n w=8u m=1
    M130 (VN0 IBIAS1 VSS VSS) NMOS_LVT_GENERIC l=60n w=4u m=1
    M164 (VBP1 IBIAS1 VSS VSS) NMOS_LVT_GENERIC l=60n w=8u m=1
    M5\<4\> (VBPP VSS VSS VSS) NMOS_LVT_GENERIC l=30n w=500n m=1
    M5\<3\> (VBPN VSS VSS VSS) NMOS_LVT_GENERIC l=30n w=500n m=1
    M5\<2\> (BNPX VSS VSS VSS) NMOS_LVT_GENERIC l=30n w=500n m=1
    M5\<1\> (BNNX VSS VSS VSS) NMOS_LVT_GENERIC l=30n w=500n m=1
    M226\<1\> (VCM2 RST2 VOCM VSS) NMOS_LVT_GENERIC l=30n w=2u m=1
    M226\<0\> (VCM2 RST2 VOCM VSS) NMOS_LVT_GENERIC l=30n w=2u m=1
    M0 (net47 VBNP VINC VSS) NMOS_LVT_GENERIC l=60n w=40u m=1
    M160 (VIPC RST VCMD VSS) NMOS_LVT_GENERIC l=30n w=5u m=1
    M2 (VBPP RST VBP1 VSS) NMOS_LVT_GENERIC l=30n w=5u m=1
    M133 (VOUTP EN BNPX VSS) NMOS_LVT_GENERIC l=30n w=2u m=1
    M132 (net46 EN VSSP VSS) NMOS_LVT_GENERIC l=30n w=5u m=1
    M82 (BNPX VBNR VSSP VSS) NMOS_LVT_GENERIC l=60n w=20u m=1
    M145 (net27 VBNN VIPC VSS) NMOS_LVT_GENERIC l=60n w=40u m=1
    M161 (VINC RST VCMD VSS) NMOS_LVT_GENERIC l=30n w=5u m=1
    M1 (VBPN RST VBP1 VSS) NMOS_LVT_GENERIC l=30n w=5u m=1
    M139 (VOUTN EN BNNX VSS) NMOS_LVT_GENERIC l=30n w=2u m=1
    M140 (net9 EN VSSN VSS) NMOS_LVT_GENERIC l=30n w=5u m=1
    M141 (BNNX VBNR VSSN VSS) NMOS_LVT_GENERIC l=60n w=20u m=1
    M214 (VP4 CMBP VDD VDD) PMOS_LVT_GENERIC l=60n w=32.0u m=1
    M187 (net3 VCM2 VP4 VDD) PMOS_LVT_GENERIC l=60n w=16.0u m=1
    M180 (net1 VOCM VP4 VDD) PMOS_LVT_GENERIC l=60n w=16.0u m=1
    M198 (VP5 CMBP VDD VDD) PMOS_LVT_GENERIC l=60n w=2u m=1
    M199 (CMBP VCM2 VP5 VDD) PMOS_LVT_GENERIC l=60n w=2u m=1
    M238 (VBPR RSTP VBP2 VDD) PMOS_LVT_GENERIC l=30n w=2u m=1
    M240 (VBNR RSTP VBN2 VDD) PMOS_LVT_GENERIC l=30n w=2u m=1
    M231 (net8 PBIAS VDD VDD) PMOS_LVT_GENERIC l=60n w=6u m=1
    M230 (net7 VCP net8 VDD) PMOS_LVT_GENERIC l=60n w=6u m=1
    M9 (VSSR ENP net7 VDD) PMOS_LVT_GENERIC l=30n w=3u m=1
    M243\<7\> (VDD VDD VP1 VDD) PMOS_LVT_GENERIC l=60n w=1u m=1
    M243\<6\> (VP2 VDD VP1 VDD) PMOS_LVT_GENERIC l=60n w=1u m=1
    M243\<5\> (VBP1 VDD VP2 VDD) PMOS_LVT_GENERIC l=60n w=1u m=1
    M243\<4\> (VBN1 VDD VBP1 VDD) PMOS_LVT_GENERIC l=60n w=1u m=1
    M243\<3\> (VDD VDD VBN1 VDD) PMOS_LVT_GENERIC l=60n w=1u m=1
    M243\<2\> (VDD VDD VP3 VDD) PMOS_LVT_GENERIC l=60n w=1u m=1
    M243\<1\> (VDD VDD VP3 VDD) PMOS_LVT_GENERIC l=60n w=1u m=1
    M242\<4\> (VDD VDD VDD VDD) PMOS_LVT_GENERIC l=60n w=13.0u m=1
    M242\<3\> (VDD VDD VDD VDD) PMOS_LVT_GENERIC l=60n w=13.0u m=1
    M242\<2\> (VDD VDD VDD VDD) PMOS_LVT_GENERIC l=60n w=13.0u m=1
    M242\<1\> (VDD VDD VDD VDD) PMOS_LVT_GENERIC l=60n w=13.0u m=1
    M94 (VP3 PBIAS VDD VDD) PMOS_LVT_GENERIC l=60n w=4u m=1
    M97 (VBP2 VBP2 VDD VDD) PMOS_LVT_GENERIC l=60n w=4u m=1
    M211 (VBN2 VCP VP3 VDD) PMOS_LVT_GENERIC l=60n w=4u m=1
    M178 (VP1 PBIAS VDD VDD) PMOS_LVT_GENERIC l=60n w=8u m=1
    M177 (VBN1 PBIAS VDD VDD) PMOS_LVT_GENERIC l=60n w=4u m=1
    M176 (VP2 PBIAS VDD VDD) PMOS_LVT_GENERIC l=60n w=4u m=1
    M174 (VBN1 PBIAS VDD VDD) PMOS_LVT_GENERIC l=60n w=8u m=1
    M173 (PBIAS VCP VP1 VDD) PMOS_LVT_GENERIC l=60n w=8u m=1
    M127 (VCP VCP VBN1 VDD) PMOS_LVT_GENERIC l=60n w=4u m=1
    M126 (VCN VCP VP2 VDD) PMOS_LVT_GENERIC l=60n w=4u m=1
    M171 (VBP1 VBP1 VCMD VDD) PMOS_LVT_GENERIC l=60n w=8u m=1
    M4\<4\> (VDD VDD VBNP VDD) PMOS_LVT_GENERIC l=30n w=500n m=1
    M4\<3\> (VDD VDD VBNN VDD) PMOS_LVT_GENERIC l=30n w=500n m=1
    M4\<2\> (VDD VDD BPPX VDD) PMOS_LVT_GENERIC l=30n w=500n m=1
    M4\<1\> (VDD VDD BPNX VDD) PMOS_LVT_GENERIC l=30n w=500n m=1
    M7 (VP5 VDD VP4 VDD) PMOS_LVT_GENERIC l=60n w=1u m=1
    M83 (BPPX VBPR VDDP VDD) PMOS_LVT_GENERIC l=60n w=20u m=1
    M128 (net47 ENP VDDP VDD) PMOS_LVT_GENERIC l=30n w=5u m=1
    M158 (VBN1 RSTP VBNP VDD) PMOS_LVT_GENERIC l=30n w=5u m=1
    M129 (VOUTP ENP BPPX VDD) PMOS_LVT_GENERIC l=30n w=2u m=1
    M159 (VCMD RSTP VIPC VDD) PMOS_LVT_GENERIC l=30n w=5u m=1
    M3 (net46 VBPP VINC VDD) PMOS_LVT_GENERIC l=60n w=40u m=1
    M134 (BPNX VBPR VDDN VDD) PMOS_LVT_GENERIC l=60n w=20u m=1
    M135 (net27 ENP VDDN VDD) PMOS_LVT_GENERIC l=30n w=5u m=1
    M163 (VBN1 RSTP VBNN VDD) PMOS_LVT_GENERIC l=30n w=5u m=1
    M138 (VOUTN ENP BPNX VDD) PMOS_LVT_GENERIC l=30n w=2u m=1
    M162 (VCMD RSTP VINC VDD) PMOS_LVT_GENERIC l=30n w=5u m=1
    M144 (net9 VBPN VIPC VDD) PMOS_LVT_GENERIC l=60n w=40u m=1
    I21\<1\> (EN0 VBSP VDDC VIP VSSC) block_b2
    I21\<0\> (EN0 VBSN VDDC VIN VSSC) block_b2
    I145 (VSSC VDDR VSS) block_b3
    I144 (VSSC VSSR VSS) block_b3
    C3 (VBN2 VDD) MOMCAP_GENERIC c_nom=1.28013p
    C2 (VBP2 VDD) MOMCAP_GENERIC c_nom=1.28013p
    C30 (VOCM VOUTP) MOMCAP_GENERIC c_nom=68.0053f
    C31 (VOCM VOUTN) MOMCAP_GENERIC c_nom=68.0053f
    C29 (VDDR VBPR) MOMCAP_GENERIC c_nom=102.926f
    C28 (VSSR VBNR) MOMCAP_GENERIC c_nom=102.926f
    C1 (VBN1 VCMD) MOMCAP_GENERIC c_nom=1.28013p
    C0 (VBP1 VCMD) MOMCAP_GENERIC c_nom=1.28013p
    M10 (VDDP RSTP2 VDDC VDD) PMOS_GENERIC l=30n w=10u m=1
    M11 (VDDN RSTP2 VDDC VDD) PMOS_GENERIC l=30n w=10u m=1
    M47 (VDDC RSTP VDDR VDD) PMOS_GENERIC l=30n w=5u m=1
    I141 (net3 net4) iprobe
ends block_b4
// End of subcircuit definition.

// Cell: design_b_top
subckt design_b_top EN0 IBIAS1 IBIAS2 RST0 VCM2 VCMD VDD VDDC VDDN VDDP VIN VIP VOUTN VOUTP VSS VSSC VSSN VSSP
I152 (net2 RSTP VDDC VSSC) INV_GENERIC_X4
I153 (net1 RST VDDC VSSC) INV_GENERIC_X4
I157 (net3 RST2 VDDC VSSC) INV_GENERIC_X4
I158 (net4 RSTP2 VDDC VSSC) INV_GENERIC_X4
I149 (net5 ENP VDDC VSSC) INV_GENERIC_X4
I150 (net6 EN VDDC VSSC) INV_GENERIC_X4
I139\<5\> (VINC VBPN VSS) block_b1
I139\<4\> (VINC VBPN VSS) block_b1
I139\<3\> (VINC VBPN VSS) block_b1
I139\<2\> (VINC VBPN VSS) block_b1
I139\<1\> (VINC VBPN VSS) block_b1
I138\<5\> (VIPC VBPP VSS) block_b1
I138\<4\> (VIPC VBPP VSS) block_b1
I138\<3\> (VIPC VBPP VSS) block_b1
I138\<2\> (VIPC VBPP VSS) block_b1
I138\<1\> (VIPC VBPP VSS) block_b1
I137\<5\> (VIPC VBNP VSS) block_b1
I137\<4\> (VIPC VBNP VSS) block_b1
I137\<3\> (VIPC VBNP VSS) block_b1
I137\<2\> (VIPC VBNP VSS) block_b1
I137\<1\> (VIPC VBNP VSS) block_b1
I140\<5\> (VINC VBNN VSS) block_b1
I140\<4\> (VINC VBNN VSS) block_b1
I140\<3\> (VINC VBNN VSS) block_b1
I140\<2\> (VINC VBNN VSS) block_b1
I140\<1\> (VINC VBNN VSS) block_b1
I1 (EN EN0 ENP IBIAS1 IBIAS2 RST RST2 RSTP RSTP2 VBNN VBNP VBPN VBPP VCM2 VCMD VDD VDDC VDDN VDDP VIN VINC VIP VIPC VOUTN VOUTP VSS VSSC VSSN VSSP) block_b4
I159\<4\> (VDDC VSSC) DECAP_GENERIC
I159\<3\> (VDDC VSSC) DECAP_GENERIC
I159\<2\> (VDDC VSSC) DECAP_GENERIC
I159\<1\> (VDDC VSSC) DECAP_GENERIC
I151 (RST0 net1 VDDC VSSC) INV_GENERIC_X2
I155 (RST0 net3 VDDC VSSC) INV_GENERIC_X2
I147 (EN0 net6 VDDC VSSC) INV_GENERIC_X2
I160\<9\> (VDDP VSSP VSS) block_b3
I160\<8\> (VDDP VSSP VSS) block_b3
I160\<7\> (VDDP VSSP VSS) block_b3
I160\<6\> (VDDP VSSP VSS) block_b3
I160\<5\> (VDDP VSSP VSS) block_b3
I160\<4\> (VDDP VSSP VSS) block_b3
I160\<3\> (VDDP VSSP VSS) block_b3
I160\<2\> (VDDP VSSP VSS) block_b3
I160\<1\> (VDDP VSSP VSS) block_b3
I161\<9\> (VDDN VSSN VSS) block_b3
I161\<8\> (VDDN VSSN VSS) block_b3
I161\<7\> (VDDN VSSN VSS) block_b3
I161\<6\> (VDDN VSSN VSS) block_b3
I161\<5\> (VDDN VSSN VSS) block_b3
I161\<4\> (VDDN VSSN VSS) block_b3
I161\<3\> (VDDN VSSN VSS) block_b3
I161\<2\> (VDDN VSSN VSS) block_b3
I161\<1\> (VDDN VSSN VSS) block_b3
I154 (net1 net2 VDDC VSSC) INV_GENERIC_X1
I156 (net3 net4 VDDC VSSC) INV_GENERIC_X1
I148 (net6 net5 VDDC VSSC) INV_GENERIC_X1
ends design_b_top
