// SPDX-License-Identifier: CERN-OHL-P-2.0
// Licensed under CERN Open Hardware Licence Version 2 - Permissive.
// See ../LICENSE.
// Sanitized release: hierarchy and transistor W/L retained.
// Generic models are placeholders and are not performance-equivalent.
simulator lang=spectre
global 0
include "generic_models.scs"

// Cell: block_a1
subckt block_a1 BOT TOP VSS
    C2 (BOT TOP) MOMCAP_GENERIC c_nom=270.243f
    C0 (TOP BOT) MOMCAP_GENERIC c_nom=270.243f
    C3 (BOT VSS) capacitor c=5f
    C1 (TOP VSS) capacitor c=5f
ends block_a1
// End of subcircuit definition.

// Cell: block_a2
subckt block_a2 CLK CLKBS VDD VIN VSS
    M0 (CLKBS net1 TOP TOP) PMOS_GENERIC l=30n w=4u m=1
    M1 (TOP CLKBS VDD TOP) PMOS_GENERIC l=30n w=2u m=1
    C0 (TOP BOT) MOMCAP_GENERIC c_nom=137.847f
    M14 (net1 CLKBS BOT VSS) NMOS_GENERIC l=30n w=2u m=1
    M7 (net2 PHIE VSS VSS) NMOS_GENERIC l=30n w=4u m=1
    M3 (CLKBS VDD net2 VSS) NMOS_GENERIC l=30n w=4u m=1
    M15 (BOT PHIE VSS VSS) NMOS_GENERIC l=30n w=2u m=1
    M13 (VIN CLKBS BOT VSS) NMOS_GENERIC l=30n w=4u m=1
    M12 (CLKBUF PHIE VDD VDD) PMOS_LVT_GENERIC l=30n w=1.04u m=1
    M6 (PHIE CLK VDD VDD) PMOS_LVT_GENERIC l=30n w=1.04u m=1
    M8 (net1 CLKBUF VDD VDD) PMOS_LVT_GENERIC l=30n w=2.08u m=1
    M11 (CLKBUF PHIE VSS VSS) NMOS_LVT_GENERIC l=30n w=800n m=1
    M4 (net1 CLKBUF BOT VSS) NMOS_LVT_GENERIC l=30n w=1.6u m=1
    M5 (PHIE CLK VSS VSS) NMOS_LVT_GENERIC l=30n w=800n m=1
ends block_a2
// End of subcircuit definition.

// Cell: block_a3
subckt block_a3 CA0 CAB CABP VBN1 VBN2 VBP1 VBP2 VDDA VDDC VDDN VDDP VIN VIP VOUTN VOUTP VSS VSSC VSSN VSSP
    I127\<5\> (VSSP VDDP VSS) block_a1
    I127\<4\> (VSSP VDDP VSS) block_a1
    I127\<3\> (VSSP VDDP VSS) block_a1
    I127\<2\> (VSSP VDDP VSS) block_a1
    I127\<1\> (VSSP VDDP VSS) block_a1
    I128\<5\> (VSSN VDDN VSS) block_a1
    I128\<4\> (VSSN VDDN VSS) block_a1
    I128\<3\> (VSSN VDDN VSS) block_a1
    I128\<2\> (VSSN VDDN VSS) block_a1
    I128\<1\> (VSSN VDDN VSS) block_a1
    M48 (VOUTP VBP VOUTP0 VSS) NMOS_GENERIC l=30n w=10u m=3
    M47 (VOUTN VBN VOUTN0 VSS) NMOS_GENERIC l=30n w=10u m=3
    M12 (VBP2 CAB net2 VSS) NMOS_GENERIC l=30n w=2.5u m=1
    M15 (VBN2 CAB net1 VSS) NMOS_GENERIC l=30n w=2.5u m=1
    M14 (VBP2 CAB net4 VSS) NMOS_GENERIC l=30n w=2.5u m=1
    M17 (VBN2 CAB net3 VSS) NMOS_GENERIC l=30n w=2.5u m=1
    M1 (VSSC CAB VSSP VSS) NMOS_GENERIC l=30n w=7u m=1
    M2 (VSSC CAB VSSN VSS) NMOS_GENERIC l=30n w=7u m=1
    M19 (net2 CABP VBP2 VDDA) PMOS_GENERIC l=30n w=2.5u m=1
    M16 (net1 CABP VBN2 VDDA) PMOS_GENERIC l=30n w=2.5u m=1
    M13 (net4 CABP VBP2 VDDA) PMOS_GENERIC l=30n w=2.5u m=1
    M18 (net3 CABP VBN2 VDDA) PMOS_GENERIC l=30n w=2.5u m=1
    M3 (VDDP CABP VDDC VDDA) PMOS_GENERIC l=30n w=7u m=1
    M4 (VDDN CABP VDDC VDDA) PMOS_GENERIC l=30n w=7u m=1
    C2 (net3 VSSP) MOMCAP_GENERIC c_nom=61.5064f
    C15 (net1 VSSN) MOMCAP_GENERIC c_nom=61.5064f
    C1 (net4 VDDP) MOMCAP_GENERIC c_nom=61.5064f
    C0 (net2 VDDN) MOMCAP_GENERIC c_nom=61.5064f
    M10 (VDDP VBN1 VIP VSS) NMOS_LVT_GENERIC l=30n w=10u m=1
    M8 (VOUTP0 net1 VSSP VSS) NMOS_LVT_GENERIC l=30n w=10u m=1
    M5 (VDDN VBN1 VIN VSS) NMOS_LVT_GENERIC l=30n w=10u m=1
    M7 (VOUTN0 net3 VSSN VSS) NMOS_LVT_GENERIC l=30n w=10u m=1
    M11 (VOUTP0 net2 VDDP VDDA) PMOS_LVT_GENERIC l=30n w=10u m=1
    M9 (VSSP VBP1 VIP VDDA) PMOS_LVT_GENERIC l=30n w=10u m=1
    M6 (VOUTN0 net4 VDDN VDDA) PMOS_LVT_GENERIC l=30n w=10u m=1
    M0 (VSSN VBP1 VIN VDDA) PMOS_LVT_GENERIC l=30n w=10u m=1
    I21\<1\> (CA0 VBP VDDC VOUTP0 VSSC) block_a2
    I21\<0\> (CA0 VBN VDDC VOUTN0 VSSC) block_a2
ends block_a3
// End of subcircuit definition.

// Cell: block_a4
subckt block_a4 IBIAS VBN0 VBP0 VCM VDDA VIN VIP VSS
    M12 (IBIAS IBIAS VSS VSS) NMOS_GENERIC l=60n w=4u m=1
    M9 (net5 IBIAS VSS VSS) NMOS_GENERIC l=60n w=4u m=1
    M10 (net4 NBIAS VSS VSS) NMOS_GENERIC l=60n w=4u m=1
    M17 (VSS VSS VSS VSS) NMOS_GENERIC l=60n w=8u m=1
    M11 (PBIAS IBIAS VSS VSS) NMOS_GENERIC l=60n w=8u m=1
    M27 (net4 VCM VSS VSS) NMOS_GENERIC l=60n w=4u m=1
    M24 (VSN NBIAS VSS VSS) NMOS_GENERIC l=60n w=20u m=2
    M16\<1\> (VSN VBP0 VSS VSS) NMOS_GENERIC l=60n w=20u m=1
    M16\<0\> (VSN VBN0 VSS VSS) NMOS_GENERIC l=60n w=20u m=1
    M122 (NBIAS VCM net4 VSS) NMOS_LVT_GENERIC l=60n w=4u m=1
    M13 (NBIAS VCM net4 VSS) NMOS_LVT_GENERIC l=60n w=4u m=1
    M6 (VSN VSS VSS VSS) NMOS_LVT_GENERIC l=60n w=1u m=1
    M18 (NBIAS VSS VSN VSS) NMOS_LVT_GENERIC l=60n w=1u m=1
    M3 (VSS VSS VSS VSS) NMOS_LVT_GENERIC l=60n w=8u m=1
    M109 (VBN0 VIN VSN VSS) NMOS_LVT_GENERIC l=60n w=40u m=1
    M108 (VBP0 VIP VSN VSS) NMOS_LVT_GENERIC l=60n w=40u m=1
    M123 (PBIAS VCM PB1 VDDA) PMOS_LVT_GENERIC l=60n w=8u m=1
    M2 (VSP VDDA VDDA VDDA) PMOS_LVT_GENERIC l=60n w=1u m=1
    M1 (VDDA VDDA VDDA VDDA) PMOS_LVT_GENERIC l=60n w=8u m=1
    M4 (PBIAS VDDA VSP VDDA) PMOS_LVT_GENERIC l=60n w=1u m=1
    M99 (VBN0 VIN VSP VDDA) PMOS_LVT_GENERIC l=60n w=40u m=1
    M98 (VBP0 VIP VSP VDDA) PMOS_LVT_GENERIC l=60n w=40u m=1
    M15 (NBIAS net5 VDDA VDDA) PMOS_GENERIC l=60n w=8u m=1
    M23 (PB1 PBIAS VDDA VDDA) PMOS_GENERIC l=60n w=8u m=1
    M14 (net5 net5 VDDA VDDA) PMOS_GENERIC l=60n w=4u m=1
    M8 (VSP PBIAS VDDA VDDA) PMOS_GENERIC l=60n w=20u m=4
    M0 (VDDA VDDA VDDA VDDA) PMOS_GENERIC l=60n w=12.0u m=1
    C1 (NBIAS VSS) MOMCAP_GENERIC c_nom=930.239f
    C0 (PBIAS VDDA) MOMCAP_GENERIC c_nom=930.239f
    IPRB0 (VSS VSS) iprobe
ends block_a4
// End of subcircuit definition.

// Cell: block_a5
subckt block_a5 CAB CABP IBIAS1 IBIAS2 VBN1 VBN2 VBP1 VBP2 VCMB VCMC VDDA VDDN VDDP VIN VIP VOUTN VOUTP VSS VSSN VSSP
    C1 (VCMC VBN1) MOMCAP_GENERIC c_nom=771.922f
    C0 (VCMC VBP1) MOMCAP_GENERIC c_nom=771.922f
    C17\<1\> (VBPP VBP) MOMCAP_GENERIC c_nom=193.989f
    C17\<0\> (VBPN VBN) MOMCAP_GENERIC c_nom=193.989f
    C18\<1\> (VBNP VBP) MOMCAP_GENERIC c_nom=193.989f
    C18\<0\> (VBNN VBN) MOMCAP_GENERIC c_nom=193.989f
    C12 (net9 VSSP) MOMCAP_GENERIC c_nom=109.109f
    C14 (net10 VDDP) MOMCAP_GENERIC c_nom=109.109f
    C15 (net8 VSSN) MOMCAP_GENERIC c_nom=109.109f
    C19 (net1 VDDN) MOMCAP_GENERIC c_nom=109.109f
    M26\<1\> (VBP2 VDDA VBNP VDDA) PMOS_GENERIC l=30n w=500n m=1
    M26\<0\> (VBP2 VDDA VBNN VDDA) PMOS_GENERIC l=30n w=500n m=1
    M16 (net8 CABP VBN2 VDDA) PMOS_GENERIC l=30n w=5u m=1
    M28\<1\> (VBNP CABP VBN1 VDDA) PMOS_GENERIC l=30n w=5u m=1
    M28\<0\> (VBNN CABP VBN1 VDDA) PMOS_GENERIC l=30n w=5u m=1
    M11 (net1 CABP VBP2 VDDA) PMOS_GENERIC l=30n w=4.5u m=1
    M18 (net9 CABP VBN2 VDDA) PMOS_GENERIC l=30n w=5u m=1
    M13 (net10 CABP VBP2 VDDA) PMOS_GENERIC l=30n w=4.5u m=1
    M22\<1\> (VBN CABP VBP VDDA) PMOS_LVT_GENERIC l=30n w=5u m=1
    M22\<0\> (VBP CABP VBN VDDA) PMOS_LVT_GENERIC l=30n w=5u m=1
    M47 (VDDA PBIAS VDDA VDDA) PMOS_LVT_GENERIC l=100n w=2u m=1
    M43 (VBN1 PBIAS VDDA VDDA) PMOS_LVT_GENERIC l=100n w=10u m=1
    M45 (PBIAS PBIAS VDDA VDDA) PMOS_LVT_GENERIC l=100n w=2u m=1
    M41 (VBP1 VBP1 VCMC VDDA) PMOS_LVT_GENERIC l=30n w=5u m=1
    M53 (VBP2 VBP2 VDDA VDDA) PMOS_LVT_GENERIC l=30n w=5u m=1
    M51 (VBN2 PBIAS VDDA VDDA) PMOS_LVT_GENERIC l=100n w=10u m=1
    M34\<1\> (VBN CABP VBP VDDA) PMOS_LVT_GENERIC l=30n w=5u m=1
    M34\<0\> (VBP CABP VBN VDDA) PMOS_LVT_GENERIC l=30n w=5u m=1
    M4 (VOUTP net1 VDDP VDDA) PMOS_LVT_GENERIC l=30n w=10u m=3
    M2 (VSSP VBPP VIP VDDA) PMOS_LVT_GENERIC l=30n w=10u m=3
    M5 (VOUTN net10 VDDN VDDA) PMOS_LVT_GENERIC l=30n w=10u m=3
    M3 (VSSN VBPN VIN VDDA) PMOS_LVT_GENERIC l=30n w=10u m=3
    M21\<1\> (VBP CAB VBN VSS) NMOS_LVT_GENERIC l=30n w=5u m=1
    M21\<0\> (VBN CAB VBP VSS) NMOS_LVT_GENERIC l=30n w=5u m=1
    M42 (VBN1 VBN1 VCMC VSS) NMOS_LVT_GENERIC l=30n w=5u m=1
    M48 (IBIAS1 IBIAS1 VSS VSS) NMOS_LVT_GENERIC l=100n w=2u m=1
    M54 (VBP2 IBIAS1 VSS VSS) NMOS_LVT_GENERIC l=100n w=10u m=1
    M52 (VBN2 VBN2 VSS VSS) NMOS_LVT_GENERIC l=30n w=5u m=1
    M46 (PBIAS IBIAS1 VSS VSS) NMOS_LVT_GENERIC l=100n w=2u m=1
    M44 (VBP1 IBIAS1 VSS VSS) NMOS_LVT_GENERIC l=100n w=10u m=1
    M33\<1\> (VBP CAB VBN VSS) NMOS_LVT_GENERIC l=30n w=5u m=1
    M33\<0\> (VBN CAB VBP VSS) NMOS_LVT_GENERIC l=30n w=5u m=1
    M0 (VDDP VBNP VIP VSS) NMOS_LVT_GENERIC l=30n w=10u m=3
    M6 (VOUTP net8 VSSP VSS) NMOS_LVT_GENERIC l=30n w=10u m=3
    M1 (VDDN VBNN VIN VSS) NMOS_LVT_GENERIC l=30n w=10u m=3
    M7 (VOUTN net9 VSSN VSS) NMOS_LVT_GENERIC l=30n w=10u m=3
    I1 (IBIAS2 VBN0 VBP0 VCMB VDDA VIN VIP VSS) block_a4
    M15 (VBN2 CAB net8 VSS) NMOS_GENERIC l=30n w=4.5u m=1
    M27\<1\> (VBPP CAB VBP1 VSS) NMOS_GENERIC l=30n w=5u m=1
    M27\<0\> (VBPN CAB VBP1 VSS) NMOS_GENERIC l=30n w=5u m=1
    M25\<1\> (VBN2 VSS VBPP VSS) NMOS_GENERIC l=30n w=500n m=1
    M25\<0\> (VBN2 VSS VBPN VSS) NMOS_GENERIC l=30n w=500n m=1
    M12 (VBP2 CAB net1 VSS) NMOS_GENERIC l=30n w=5u m=1
    M17 (VBN2 CAB net9 VSS) NMOS_GENERIC l=30n w=4.5u m=1
    M14 (VBP2 CAB net10 VSS) NMOS_GENERIC l=30n w=5u m=1
    I2 (VBP0 VBN0 VBP VBN) DIFF_PROBE_GENERIC
ends block_a5
// End of subcircuit definition.

// Cell: block_a6
subckt block_a6 CAB CAB0 CABP IBIAS1 IBIAS2 VBN1 VBN2 VBP1 VBP2 VCMB VCMC VDD VDDC VDDN VDDP VIN VIP VOUTN VOUTP VSS VSSC VSSN VSSP
    M1 (VSSC CAB VSSP VSS) NMOS_GENERIC l=30n w=10u m=3
    M2 (VSSC CAB VSSN VSS) NMOS_GENERIC l=30n w=10u m=3
    I137\<4\> (VDDC VSSC) DECAP_GENERIC
    I137\<3\> (VDDC VSSC) DECAP_GENERIC
    I137\<2\> (VDDC VSSC) DECAP_GENERIC
    I137\<1\> (VDDC VSSC) DECAP_GENERIC
    I127\<20\> (VSSP VDDP VSS) block_a1
    I127\<19\> (VSSP VDDP VSS) block_a1
    I127\<18\> (VSSP VDDP VSS) block_a1
    I127\<17\> (VSSP VDDP VSS) block_a1
    I127\<16\> (VSSP VDDP VSS) block_a1
    I127\<15\> (VSSP VDDP VSS) block_a1
    I127\<14\> (VSSP VDDP VSS) block_a1
    I127\<13\> (VSSP VDDP VSS) block_a1
    I127\<12\> (VSSP VDDP VSS) block_a1
    I127\<11\> (VSSP VDDP VSS) block_a1
    I127\<10\> (VSSP VDDP VSS) block_a1
    I127\<9\> (VSSP VDDP VSS) block_a1
    I127\<8\> (VSSP VDDP VSS) block_a1
    I127\<7\> (VSSP VDDP VSS) block_a1
    I127\<6\> (VSSP VDDP VSS) block_a1
    I127\<5\> (VSSP VDDP VSS) block_a1
    I127\<4\> (VSSP VDDP VSS) block_a1
    I127\<3\> (VSSP VDDP VSS) block_a1
    I127\<2\> (VSSP VDDP VSS) block_a1
    I127\<1\> (VSSP VDDP VSS) block_a1
    I128\<20\> (VSSN VDDN VSS) block_a1
    I128\<19\> (VSSN VDDN VSS) block_a1
    I128\<18\> (VSSN VDDN VSS) block_a1
    I128\<17\> (VSSN VDDN VSS) block_a1
    I128\<16\> (VSSN VDDN VSS) block_a1
    I128\<15\> (VSSN VDDN VSS) block_a1
    I128\<14\> (VSSN VDDN VSS) block_a1
    I128\<13\> (VSSN VDDN VSS) block_a1
    I128\<12\> (VSSN VDDN VSS) block_a1
    I128\<11\> (VSSN VDDN VSS) block_a1
    I128\<10\> (VSSN VDDN VSS) block_a1
    I128\<9\> (VSSN VDDN VSS) block_a1
    I128\<8\> (VSSN VDDN VSS) block_a1
    I128\<7\> (VSSN VDDN VSS) block_a1
    I128\<6\> (VSSN VDDN VSS) block_a1
    I128\<5\> (VSSN VDDN VSS) block_a1
    I128\<4\> (VSSN VDDN VSS) block_a1
    I128\<3\> (VSSN VDDN VSS) block_a1
    I128\<2\> (VSSN VDDN VSS) block_a1
    I128\<1\> (VSSN VDDN VSS) block_a1
    I130\<1\> (net14 CAB VDDC VSSC) INV_GENERIC_X2
    I130\<0\> (net14 CAB VDDC VSSC) INV_GENERIC_X2
    I135\<1\> (net15 CABP VDDC VSSC) INV_GENERIC_X2
    I135\<0\> (net15 CABP VDDC VSSC) INV_GENERIC_X2
    I129 (CAB0 net14 VDDC VSSC) INV_GENERIC_X1
    I136 (CAB0 net13 VDDC VSSC) INV_GENERIC_X1
    I134 (net13 net15 VDDC VSSC) INV_GENERIC_X1
    M3 (VDDP CABP VDDC VDDC) PMOS_GENERIC l=30n w=10u m=3
    M4 (VDDN CABP VDDC VDDC) PMOS_GENERIC l=30n w=10u m=3
    C1 (VBN2 VSS) MOMCAP_GENERIC c_nom=385.444f
    C0 (VBP2 VDD) MOMCAP_GENERIC c_nom=385.444f
    I1 (CAB CABP IBIAS1 IBIAS2 VBN1 VBN2 VBP1 VBP2 VCMB VCMC VDD VDDN VDDP VIN VIP VOUTN VOUTP VSS VSSN VSSP) block_a5
ends block_a6
// End of subcircuit definition.

// Cell: design_a_top
subckt design_a_top CA0 CAB0 IBIAS1 IBIAS2 VCMB VCMC VDD VDDC VDDN VDDP VIN VIP VOUTN VOUTP VSS VSSC VSSN VSSP
I142 (CA0 CAB CABP VBN1 VBN2 VBP1 VBP2 VDD VDDC VDDN VDDP VO1N VO1P VOUTN VOUTP VSS VSSC VSSN VSSP) block_a3
I147 (CAB CAB0 CABP IBIAS1 IBIAS2 VBN1 VBN2 VBP1 VBP2 VCMB VCMC VDD VDDC VDDN1 VDDP1 VIN VIP VO1N VO1P VSS VSSC VSSN1 VSSP1) block_a6
ends design_a_top
